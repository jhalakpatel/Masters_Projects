simulator( 'hspiceS )
design(	 "/home/ecegrid/a/559mg3/cadence/simulation/Inverter_180nm/hspiceS/schematic/netlist/Inverter_180nm.C")
resultsDir( "/home/ecegrid/a/559mg3/cadence/simulation/Inverter_180nm/hspiceS/schematic" )
analysis('tran ?from "0n"  ?to "120n"  ?by "1n"  )
save( 'i "/P0/S" )
temp( 25 )
run()
selectResult( 'tran )
plot(getData("/P0/S") getData("/vdd!") getData("/In") getData("/Out") )

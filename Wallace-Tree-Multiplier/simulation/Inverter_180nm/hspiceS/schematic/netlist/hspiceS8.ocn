simulator( 'hspiceS )
design(	 "/home/ecegrid/a/559mg3/cadence/simulation/Inverter_180nm/hspiceS/schematic/netlist/Inverter_180nm.C")
resultsDir( "/home/ecegrid/a/559mg3/cadence/simulation/Inverter_180nm/hspiceS/schematic" )
analysis('tran ?from "0n"  ?to "30n"  ?by "1n"  )
temp( 25 )
run()
run()
run()
run()

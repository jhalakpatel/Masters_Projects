simulator( 'hspiceS )
design(	 "/home/ecegrid/a/559mg3/cadence/simulation/Inverter_180nm/hspiceS/schematic/netlist/Inverter_180nm.C")
resultsDir( "/home/ecegrid/a/559mg3/cadence/simulation/Inverter_180nm/hspiceS/schematic" )
analysis('tran ?from "0n"  ?to "30n"  ?by "1n"  )
save( 'i "/I0/vdd!" )
temp( 25 )
run()
selectResult( 'tran )
plot(getData("/In") getData("/Out") getData("/I0/vdd!") )
save( 'i "/P0/S" )
run()
selectResult( 'tran )
plot(getData("/In") getData("/Out") getData("/I0/vdd!") getData("/P0/S") )
save( 'i /I0/vdd! )
run()
selectResult( 'tran )
plot(getData("/In") getData("/Out") getData("/P0/S") )
run()
selectResult( 'tran )
plot(getData("/In") getData("/Out") getData("/P0/S") )
run()
selectResult( 'tran )
plot(getData("/In") getData("/Out") getData("/P0/S") )
T_RISE = delay(VT("/Out") 0.25 1 "rising" VT("/Out") 2.25 1 "rising" 0 0 nil nil)
plot( T_RISE ?expr '( "T_RISE" ) )
T_FALL = delay(VT("/Out") 2.25 1 "falling" VT("/Out") 0.25 1 "falling" 0 0 nil nil)
plot( T_FALL ?expr '( "T_FALL" ) )
run()
selectResult( 'tran )
plot(getData("/In") getData("/Out") getData("/P0/S") )
T_RISE = delay(VT("/Out") 0.25 1 "rising" VT("/Out") 2.25 1 "rising" 0 0 nil nil)
plot( T_RISE ?expr '( "T_RISE" ) )
T_FALL = delay(VT("/Out") 2.25 1 "falling" VT("/Out") 0.25 1 "falling" 0 0 nil nil)
plot( T_FALL ?expr '( "T_FALL" ) )

simulator( 'hspiceS )
design(	 "/home/ecegrid/a/559mg3/cadence/simulation/TSPC_FF_PositiveEdge/hspiceS/schematic/netlist/TSPC_FF_PositiveEdge.C")
resultsDir( "/home/ecegrid/a/559mg3/cadence/simulation/TSPC_FF_PositiveEdge/hspiceS/schematic" )
analysis('tran ?from "0n"  ?to "60n"  ?by "1n"  )
temp( 25 )
run()
selectResult( 'tran )
plot(getData("/GD") getData("/VD") getData("/clk") getData("/D_IN") getData("/Q_OUT") )
run()
selectResult( 'tran )
plot(getData("/net14") getData("/net26") getData("/net10") getData("/GD") getData("/VD") getData("/clk") getData("/D_IN") getData("/Q_OUT") )

simulator( 'hspiceS )
design(	 "/home/ecegrid/a/559mg3/cadence/simulation/Full_Adder_Mirror_StaticCMOS_LAYOUT/hspiceS/schematic/netlist/Full_Adder_Mirror_StaticCMOS_LAYOUT.C")
resultsDir( "/home/ecegrid/a/559mg3/cadence/simulation/Full_Adder_Mirror_StaticCMOS_LAYOUT/hspiceS/schematic" )
temp( 25 )
run()
run()
analysis('tran ?from "0n"  ?to "60n"  ?by "1n"  )
run()
selectResult( 'tran )
plot(getData("/CARRY_OUT") getData("/SUM_OUT") getData("/VD") getData("/GD") getData("/A_IN") getData("/B_IN") getData("/C_IN") )
run()
selectResult( 'tran )
plot(getData("/CARRY_OUT") getData("/SUM_OUT") getData("/VD") getData("/GD") getData("/A_IN") getData("/B_IN") getData("/C_IN") )
run()
selectResult( 'tran )
plot(getData("/CARRY_OUT") getData("/SUM_OUT") getData("/VD") getData("/GD") getData("/A_IN") getData("/B_IN") getData("/C_IN") )

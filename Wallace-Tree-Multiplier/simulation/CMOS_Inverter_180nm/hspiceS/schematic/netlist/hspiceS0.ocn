simulator( 'hspiceS )
design(	 "/home/ecegrid/a/559mg3/cadence/simulation/CMOS_Inverter_180nm/hspiceS/schematic/netlist/CMOS_Inverter_180nm.C")
resultsDir( "/home/ecegrid/a/559mg3/cadence/simulation/CMOS_Inverter_180nm/hspiceS/schematic" )
analysis('tran ?from "0n"  ?to "30n"  ?by "1n"  )
desVar(	  "R" 1	)
desVar(	  "WIDTH" 270n	)
desVar(	  "WIDTHN" 270n	)
temp( 25 )
run()
t_falltime = delay(VT("/In") 1.25 1 "rising" VT("/Out") 1.25 1 "falling" 0 0 nil nil)
plot( t_falltime ?expr '( "t_falltime" ) )
t_risetime = delay(VT("/In") 1.25 1 "falling" VT("/Out") 1.25 1 "rising" 0 0 nil nil)
plot( t_risetime ?expr '( "t_risetime" ) )
run()
selectResult( 'tran )
plot(getData("/In") getData("/Out") )
t_falltime = delay(VT("/In") 1.25 1 "rising" VT("/Out") 1.25 1 "falling" 0 0 nil nil)
plot( t_falltime ?expr '( "t_falltime" ) )
t_risetime = delay(VT("/In") 1.25 1 "falling" VT("/Out") 1.25 1 "rising" 0 0 nil nil)
plot( t_risetime ?expr '( "t_risetime" ) )
desVar(	  "WIDTH" 360n	)
desVar(	  "WIDTHN" 360n	)
run()
selectResult( 'tran )
plot(getData("/In") getData("/Out") )
t_falltime = delay(VT("/In") 1.25 1 "rising" VT("/Out") 1.25 1 "falling" 0 0 nil nil)
plot( t_falltime ?expr '( "t_falltime" ) )
t_risetime = delay(VT("/In") 1.25 1 "falling" VT("/Out") 1.25 1 "rising" 0 0 nil nil)
plot( t_risetime ?expr '( "t_risetime" ) )
desVar(	  "R" 4	)
run()
selectResult( 'tran )
plot(getData("/In") getData("/Out") )
t_falltime = delay(VT("/In") 1.25 1 "rising" VT("/Out") 1.25 1 "falling" 0 0 nil nil)
plot( t_falltime ?expr '( "t_falltime" ) )
t_risetime = delay(VT("/In") 1.25 1 "falling" VT("/Out") 1.25 1 "rising" 0 0 nil nil)
plot( t_risetime ?expr '( "t_risetime" ) )
desVar(	  "R" 3.4	)
run()
selectResult( 'tran )
plot(getData("/In") getData("/Out") )
t_falltime = delay(VT("/In") 1.25 1 "rising" VT("/Out") 1.25 1 "falling" 0 0 nil nil)
plot( t_falltime ?expr '( "t_falltime" ) )
t_risetime = delay(VT("/In") 1.25 1 "falling" VT("/Out") 1.25 1 "rising" 0 0 nil nil)
plot( t_risetime ?expr '( "t_risetime" ) )
desVar(	  "R" 3.5	)
run()
selectResult( 'tran )
plot(getData("/In") getData("/Out") )
t_falltime = delay(VT("/In") 1.25 1 "rising" VT("/Out") 1.25 1 "falling" 0 0 nil nil)
plot( t_falltime ?expr '( "t_falltime" ) )
t_risetime = delay(VT("/In") 1.25 1 "falling" VT("/Out") 1.25 1 "rising" 0 0 nil nil)
plot( t_risetime ?expr '( "t_risetime" ) )
desVar(	  "R" 3.3	)
run()
selectResult( 'tran )
plot(getData("/In") getData("/Out") )
t_falltime = delay(VT("/In") 1.25 1 "rising" VT("/Out") 1.25 1 "falling" 0 0 nil nil)
plot( t_falltime ?expr '( "t_falltime" ) )
t_risetime = delay(VT("/In") 1.25 1 "falling" VT("/Out") 1.25 1 "rising" 0 0 nil nil)
plot( t_risetime ?expr '( "t_risetime" ) )
desVar(	  "R" 3.6	)
run()
selectResult( 'tran )
plot(getData("/In") getData("/Out") )
t_falltime = delay(VT("/In") 1.25 1 "rising" VT("/Out") 1.25 1 "falling" 0 0 nil nil)
plot( t_falltime ?expr '( "t_falltime" ) )
t_risetime = delay(VT("/In") 1.25 1 "falling" VT("/Out") 1.25 1 "rising" 0 0 nil nil)
plot( t_risetime ?expr '( "t_risetime" ) )
desVar(	  "R" 3.2	)
run()
selectResult( 'tran )
plot(getData("/In") getData("/Out") )
t_falltime = delay(VT("/In") 1.25 1 "rising" VT("/Out") 1.25 1 "falling" 0 0 nil nil)
plot( t_falltime ?expr '( "t_falltime" ) )
t_risetime = delay(VT("/In") 1.25 1 "falling" VT("/Out") 1.25 1 "rising" 0 0 nil nil)
plot( t_risetime ?expr '( "t_risetime" ) )
desVar(	  "R" 3	)
run()
selectResult( 'tran )
plot(getData("/In") getData("/Out") )
t_falltime = delay(VT("/In") 1.25 1 "rising" VT("/Out") 1.25 1 "falling" 0 0 nil nil)
plot( t_falltime ?expr '( "t_falltime" ) )
t_risetime = delay(VT("/In") 1.25 1 "falling" VT("/Out") 1.25 1 "rising" 0 0 nil nil)
plot( t_risetime ?expr '( "t_risetime" ) )
desVar(	  "R" 3.1	)
run()
selectResult( 'tran )
plot(getData("/In") getData("/Out") )
t_falltime = delay(VT("/In") 1.25 1 "rising" VT("/Out") 1.25 1 "falling" 0 0 nil nil)
plot( t_falltime ?expr '( "t_falltime" ) )
t_risetime = delay(VT("/In") 1.25 1 "falling" VT("/Out") 1.25 1 "rising" 0 0 nil nil)
plot( t_risetime ?expr '( "t_risetime" ) )
desVar(	  "R" 3.125	)
run()
selectResult( 'tran )
plot(getData("/In") getData("/Out") )
t_falltime = delay(VT("/In") 1.25 1 "rising" VT("/Out") 1.25 1 "falling" 0 0 nil nil)
plot( t_falltime ?expr '( "t_falltime" ) )
t_risetime = delay(VT("/In") 1.25 1 "falling" VT("/Out") 1.25 1 "rising" 0 0 nil nil)
plot( t_risetime ?expr '( "t_risetime" ) )
desVar(	  "R" 3.25	)
run()
selectResult( 'tran )
plot(getData("/In") getData("/Out") )
t_falltime = delay(VT("/In") 1.25 1 "rising" VT("/Out") 1.25 1 "falling" 0 0 nil nil)
plot( t_falltime ?expr '( "t_falltime" ) )
t_risetime = delay(VT("/In") 1.25 1 "falling" VT("/Out") 1.25 1 "rising" 0 0 nil nil)
plot( t_risetime ?expr '( "t_risetime" ) )
desVar(	  "WIDTH" 270n	)
desVar(	  "WIDTHN" 270n	)
run()
selectResult( 'tran )
plot(getData("/In") getData("/Out") )
t_falltime = delay(VT("/In") 1.25 1 "rising" VT("/Out") 1.25 1 "falling" 0 0 nil nil)
plot( t_falltime ?expr '( "t_falltime" ) )
t_risetime = delay(VT("/In") 1.25 1 "falling" VT("/Out") 1.25 1 "rising" 0 0 nil nil)
plot( t_risetime ?expr '( "t_risetime" ) )
desVar(	  "R" 3.389	)
run()
selectResult( 'tran )
plot(getData("/In") getData("/Out") )
t_falltime = delay(VT("/In") 1.25 1 "rising" VT("/Out") 1.25 1 "falling" 0 0 nil nil)
plot( t_falltime ?expr '( "t_falltime" ) )
t_risetime = delay(VT("/In") 1.25 1 "falling" VT("/Out") 1.25 1 "rising" 0 0 nil nil)
plot( t_risetime ?expr '( "t_risetime" ) )
desVar(	  "R" 2.9	)
run()
selectResult( 'tran )
plot(getData("/In") getData("/Out") )
t_falltime = delay(VT("/Out") 2.25 1 "falling" VT("/Out") 0.25 1 "falling" 0 0 nil nil)
plot( t_falltime ?expr '( "t_falltime" ) )
t_risetime = delay(VT("/Out") 0.25 1 "rising" VT("/Out") 2.25 1 "rising" 0 0 nil nil)
plot( t_risetime ?expr '( "t_risetime" ) )
desVar(	  "R" 2.945	)
run()
selectResult( 'tran )
plot(getData("/In") getData("/Out") )
t_falltime = delay(VT("/Out") 2.25 1 "falling" VT("/Out") 0.25 1 "falling" 0 0 nil nil)
plot( t_falltime ?expr '( "t_falltime" ) )
t_risetime = delay(VT("/Out") 0.25 1 "rising" VT("/Out") 2.25 1 "rising" 0 0 nil nil)
plot( t_risetime ?expr '( "t_risetime" ) )
desVar(	  "R" 3	)
run()
selectResult( 'tran )
plot(getData("/In") getData("/Out") )
t_falltime = delay(VT("/Out") 2.25 1 "falling" VT("/Out") 0.25 1 "falling" 0 0 nil nil)
plot( t_falltime ?expr '( "t_falltime" ) )
t_risetime = delay(VT("/Out") 0.25 1 "rising" VT("/Out") 2.25 1 "rising" 0 0 nil nil)
plot( t_risetime ?expr '( "t_risetime" ) )

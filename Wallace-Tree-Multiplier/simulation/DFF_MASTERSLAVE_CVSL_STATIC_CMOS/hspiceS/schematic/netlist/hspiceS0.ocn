simulator( 'hspiceS )
design(	 "/home/ecegrid/a/559mg3/cadence/simulation/DFF_MASTERSLAVE_CVSL_STATIC_CMOS/hspiceS/schematic/netlist/DFF_MASTERSLAVE_CVSL_STATIC_CMOS.C")
resultsDir( "/home/ecegrid/a/559mg3/cadence/simulation/DFF_MASTERSLAVE_CVSL_STATIC_CMOS/hspiceS/schematic" )
analysis('tran ?from "0n"  ?to "60n"  ?by "1n"  )
temp( 25 )
run()
selectResult( 'tran )
plot(getData("/net84") getData("/D_IN") getData("/CLK") getData("/Q_BAR_OUT_DFF_MS_CVSL") )
run()
selectResult( 'tran )
plot(getData("/Q_OUT_DFF_MS_CVSL") getData("/net84") getData("/D_IN") getData("/CLK") getData("/Q_BAR_OUT_DFF_MS_CVSL") )
run()
selectResult( 'tran )
plot(getData("/vdd!") getData("/Q_OUT_DFF_MS_CVSL") getData("/net84") getData("/D_IN") getData("/CLK") getData("/Q_BAR_OUT_DFF_MS_CVSL") )
run()
selectResult( 'tran )
plot(getData("/Q_BAR_OUT_DFF_MS_CVSL") getData("/CLK") getData("/D_IN") getData("/net84") getData("/Q_OUT_DFF_MS_CVSL") getData("/vdd!") )
run()
selectResult( 'tran )
plot(getData("/CLK") getData("/Q_BAR_OUT_DFF_MS_CVSL") getData("/D_IN") getData("/net84") getData("/Q_OUT_DFF_MS_CVSL") getData("/vdd!") )
run()
selectResult( 'tran )
plot(getData("/net86") getData("/net112") getData("/CLK") getData("/Q_BAR_OUT_DFF_MS_CVSL") getData("/D_IN") getData("/net84") getData("/Q_OUT_DFF_MS_CVSL") getData("/vdd!") )

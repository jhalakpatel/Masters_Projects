simulator( 'spectre )
design(	 "/home/ecegrid/a/559mg3/cadence/simulation/InverterFan4_180nm/spectre/schematic/netlist/netlist")
resultsDir( "/home/ecegrid/a/559mg3/cadence/simulation/InverterFan4_180nm/spectre/schematic" )
analysis('dc ?saveOppoint t  )
analysis('tran ?stop "10u"  )
saveOption( 'currents "all" )
saveOption( 'pwr "all" )
temp( 27 )
run()
run()
run()
run()
run()
run()
selectResult( 'tran )
plot(getData("/Out<0>") getData("/Out<1>") getData("/Out<2>") getData("/Out<3>") getData("/Out_inv") getData("/In") )
selectResult( 'dcOp )
plot(getData("/Out<0>") getData("/Out<1>") getData("/Out<2>") getData("/Out<3>") getData("/Out_inv") getData("/In") )
run()
selectResult( 'tran )
plot(getData("/Out<0>") getData("/Out<1>") getData("/Out<2>") getData("/Out<3>") getData("/Out_inv") getData("/In") )
selectResult( 'dcOp )
plot(getData("/Out<0>") getData("/Out<1>") getData("/Out<2>") getData("/Out<3>") getData("/Out_inv") getData("/In") )
run()
selectResult( 'tran )
plot(getData("/Out<0>") getData("/Out<1>") getData("/Out<2>") getData("/Out<3>") getData("/Out_inv") getData("/In") )
selectResult( 'dcOp )
plot(getData("/Out<0>") getData("/Out<1>") getData("/Out<2>") getData("/Out<3>") getData("/Out_inv") getData("/In") )
modelFile(
    '("/home/ecegrid/a/559mg3/MOS_DESIGN_LAB/home_work/cds.lib" "")
)
run()
selectResult( 'tran )
plot(getData("/Out<0>") getData("/Out<1>") getData("/Out<2>") getData("/Out<3>") getData("/Out_inv") getData("/In") )
selectResult( 'dcOp )
plot(getData("/Out<0>") getData("/Out<1>") getData("/Out<2>") getData("/Out<3>") getData("/Out_inv") getData("/In") )
modelFile(
    '("/home/ecegrid/a/559mg3/MOS_DESIGN_LAB/home_work/inverter_180nm" "")
    '("/home/ecegrid/a/559mg3/MOS_DESIGN_LAB/home_work/cds.lib" "")
)
run()
selectResult( 'tran )
plot(getData("/Out<0>") getData("/Out<1>") getData("/Out<2>") getData("/Out<3>") getData("/Out_inv") getData("/In") )
selectResult( 'dcOp )
plot(getData("/Out<0>") getData("/Out<1>") getData("/Out<2>") getData("/Out<3>") getData("/Out_inv") getData("/In") )
modelFile(
    '("/home/ecegrid/a/559mg3/MOS_DESIGN_LAB/cds.lib" "")
)
run()
selectResult( 'tran )
plot(getData("/Out<0>") getData("/Out<1>") getData("/Out<2>") getData("/Out<3>") getData("/Out_inv") getData("/In") )
selectResult( 'dcOp )
plot(getData("/Out<0>") getData("/Out<1>") getData("/Out<2>") getData("/Out<3>") getData("/Out_inv") getData("/In") )
run()
selectResult( 'tran )
plot(getData("/Out<0>") getData("/Out<1>") getData("/Out<2>") getData("/Out<3>") getData("/Out_inv") getData("/In") )
selectResult( 'dcOp )
plot(getData("/Out<0>") getData("/Out<1>") getData("/Out<2>") getData("/Out<3>") getData("/Out_inv") getData("/In") )
run()
selectResult( 'tran )
plot(getData("/Out<0>") getData("/Out<1>") getData("/Out<2>") getData("/Out<3>") getData("/Out_inv") getData("/In") )
selectResult( 'dcOp )
plot(getData("/Out<0>") getData("/Out<1>") getData("/Out<2>") getData("/Out<3>") getData("/Out_inv") getData("/In") )

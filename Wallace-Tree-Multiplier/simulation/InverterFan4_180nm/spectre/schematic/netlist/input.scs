// Design: hw1/InverterFan4_180nm
simulator lang=spectre
global 0 vdd!

// hw1/Inverter_180nm/schematic
subckt Inverter_180nm In Out
    P0 (Out In vdd! vdd!) tsmc18dP w=810.0n l=180.0n m=1 region=sat
    N0 (Out In 0 0) tsmc18dN w=270.0n l=180.0n m=1 region=sat
ends Inverter_180nm

// hw1/InverterFan4_180nm/schematic
I4 (Out_inv Out\<3\>) Inverter_180nm
I3 (Out_inv Out\<2\>) Inverter_180nm
I2 (Out_inv Out\<1\>) Inverter_180nm
I1 (Out_inv Out\<0\>) Inverter_180nm
I0 (In Out_inv) Inverter_180nm
include "./_graphical_stimuli.scs"
simulatorOptions options temp=27
tran tran stop=10u
dcOp dc
saveOptions options pwr=all currents=all

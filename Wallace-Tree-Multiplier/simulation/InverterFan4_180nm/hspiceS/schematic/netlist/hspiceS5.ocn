simulator( 'hspiceS )
design(	 "/home/ecegrid/a/559mg3/cadence/simulation/InverterFan4_180nm/hspiceS/schematic/netlist/InverterFan4_180nm.C")
resultsDir( "/home/ecegrid/a/559mg3/cadence/simulation/InverterFan4_180nm/hspiceS/schematic" )
desVar(	  "R" 1	)
desVar(	  "WIDTH" 270	)
desVar(	  "WIDTHN" 270	)
temp( 25 )
run()
t_rise = delay(VT("/Out_inv") 0.25 1 "rising" VT("/Out_inv") 2.25 1 "rising" 0 0 nil nil)
plot( t_rise ?expr '( "t_rise" ) )
t_fall = delay(VT("/Out_inv") 2.25 1 "falling" VT("/Out_inv") 0.25 1 "falling" 0 0 nil nil)
plot( t_fall ?expr '( "t_fall" ) )

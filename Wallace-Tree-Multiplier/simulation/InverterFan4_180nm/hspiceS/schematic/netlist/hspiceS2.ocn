simulator( 'hspiceS )
design(	 "/home/ecegrid/a/559mg3/cadence/simulation/InverterFan4_180nm/hspiceS/schematic/netlist/InverterFan4_180nm.C")
resultsDir( "/home/ecegrid/a/559mg3/cadence/simulation/InverterFan4_180nm/hspiceS/schematic" )
analysis('tran ?from "0n"  ?to "120n"  ?by "1n"  )
save( 'i "/I5/vdd!" "/I0/Out" )
temp( 25 )
run()
selectResult( 'tran )
plot(getData("/I5/vdd!") getData("/In") getData("/Out_inv") getData("/I0/Out") )
run()
selectResult( 'tran )
plot(getData("/I5/vdd!") getData("/In") getData("/Out_inv") getData("/I0/Out") )
I_rms = rms(IT("/I0/Out"))
plot( I_rms ?expr '( "I_rms" ) )
run()
selectResult( 'tran )
plot(getData("/I5/vdd!") getData("/In") getData("/Out_inv") getData("/I0/Out") )
I_rms = rms(IT("/I0/Out"))
plot( I_rms ?expr '( "I_rms" ) )
I_vdd = IT("/I5/vdd!")
plot( I_vdd ?expr '( "I_vdd" ) )

simulator( 'hspiceS )
design(	 "/home/ecegrid/a/559mg3/cadence/simulation/FULL_ADDER_32_STATIC_CMOS/hspiceS/schematic/netlist/FULL_ADDER_32_STATIC_CMOS.C")
resultsDir( "/home/ecegrid/a/559mg3/cadence/simulation/FULL_ADDER_32_STATIC_CMOS/hspiceS/schematic" )
analysis('tran ?from "0n"  ?to "60n"  ?by "1n"  )
temp( 25 )
run()
selectResult( 'tran )
plot(getData("/A_IN") getData("/B_IN") getData("/C_IN") getData("/S_OUT_FULL_ADDER32") getData("/C_OUT_FULL_ADDER32") )
run()
selectResult( 'tran )
plot(getData("/A_IN") getData("/B_IN") getData("/C_IN") getData("/S_OUT_FULL_ADDER32") getData("/C_OUT_FULL_ADDER32") )

simulator( 'hspiceS )
design(	 "/home/ecegrid/a/559mg3/cadence/simulation/HALF_ADDER_22_STATIC_CMOS/hspiceS/schematic/netlist/HALF_ADDER_22_STATIC_CMOS.C")
resultsDir( "/home/ecegrid/a/559mg3/cadence/simulation/HALF_ADDER_22_STATIC_CMOS/hspiceS/schematic" )
analysis('tran ?from "0n"  ?to "60n"  ?by "1n"  )
temp( 25 )
run()
selectResult( 'tran )
plot(getData("/VD") getData("/GD") getData("/C_OUT_HALF_ADDER22") getData("/A_IN") getData("/B_IN") getData("/S_OUT_HALF_ADDER22") )
run()
selectResult( 'tran )
plot(getData("/VD") getData("/GD") getData("/C_OUT_HALF_ADDER22") getData("/A_IN") getData("/B_IN") getData("/S_OUT_HALF_ADDER22") )
run()
selectResult( 'tran )
plot(getData("/VD") getData("/GD") getData("/C_OUT_HALF_ADDER22") getData("/A_IN") getData("/B_IN") getData("/S_OUT_HALF_ADDER22") )
run()
selectResult( 'tran )
plot(getData("/A_IN") getData("/B_IN") getData("/C_OUT_HALF_ADDER22") getData("/S_OUT_HALF_ADDER22") getData("/GD") )
run()
selectResult( 'tran )
plot(getData("/net52") getData("/S_OUT_HALF_ADDER22") getData("/GD") getData("/net26") getData("/net46") getData("/A_IN") getData("/B_IN") getData("/C_OUT_HALF_ADDER22") )
run()
selectResult( 'tran )
plot(getData("/net26") getData("/net46") getData("/GD") getData("/A_IN") getData("/B_IN") getData("/VD") )
run()
selectResult( 'tran )
plot(getData("/net26") getData("/net46") getData("/GD") getData("/A_IN") getData("/B_IN") getData("/VD") )
run()
selectResult( 'tran )
plot(getData("/S_OUT_HALF_ADDER22") getData("/C_OUT_HALF_ADDER22") getData("/net26") getData("/net46") getData("/GD") getData("/A_IN") getData("/B_IN") getData("/VD") )

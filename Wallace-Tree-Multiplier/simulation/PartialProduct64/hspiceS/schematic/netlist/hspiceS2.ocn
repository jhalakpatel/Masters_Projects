simulator( 'hspiceS )
createFinalNetlist()
createFinalNetlist()
design(	 "/home/ecegrid/a/559mg3/cadence/simulation/PartialProduct64/hspiceS/schematic/netlist/PartialProduct64.C")
resultsDir( "/home/ecegrid/a/559mg3/cadence/simulation/PartialProduct64/hspiceS/schematic" )
temp( 25 )
run()
createFinalNetlist()
createFinalNetlist()
createFinalNetlist()
createFinalNetlist()

simulator( 'hspiceS )
design(	 "/home/ecegrid/a/559mg3/cadence/simulation/CMOS_NOR_180nm/hspiceS/schematic/netlist/CMOS_NOR_180nm.C")
resultsDir( "/home/ecegrid/a/559mg3/cadence/simulation/CMOS_NOR_180nm/hspiceS/schematic" )
analysis('tran ?from "0n"  ?to "30n"  ?by "1n"  )
desVar(	  "R" 2	)
desVar(	  "WIDTHN" 270n	)
desVar(	  "WIDTHP" 270n	)
temp( 25 )
run()
selectResult( 'tran )
plot(getData("/A") getData("/B") getData("/OUT") )
run()
selectResult( 'tran )
plot(getData("/A") getData("/B") getData("/OUT") )
desVar(	  "R" 5	)
run()
selectResult( 'tran )
plot(getData("/OUT") getData("/B") getData("/A") )
t_rise = delay(VT("/A") 1.25 1 "falling" VT("/OUT") 1.25 1 "rising" 0 0 nil nil)
plot( t_rise ?expr '( "t_rise" ) )
t_fall = delay(VT("/A") 1.25 1 "rising" VT("/OUT") 1.25 1 "falling" 0 0 nil nil)
plot( t_fall ?expr '( "t_fall" ) )

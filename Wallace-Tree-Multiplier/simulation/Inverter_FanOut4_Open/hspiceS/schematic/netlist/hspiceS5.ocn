simulator( 'hspiceS )
design(	 "/home/ecegrid/a/559mg3/cadence/simulation/Inverter_FanOut4_Open/hspiceS/schematic/netlist/Inverter_FanOut4_Open.C")
resultsDir( "/home/ecegrid/a/559mg3/cadence/simulation/Inverter_FanOut4_Open/hspiceS/schematic" )
analysis('tran ?from "0n"  ?to "120n"  ?by "1n"  )
save( 'i "/I0/vdd!" )
temp( 25 )
run()
selectResult( 'tran )
plot(getData("/I0/vdd!") getData("/IN") getData("/net18") )
run()
selectResult( 'tran )
plot(getData("/I0/vdd!") getData("/IN") getData("/net18") )
run()
selectResult( 'tran )
plot(getData("/OUT_INV") getData("/I0/vdd!") getData("/IN") )
run()
selectResult( 'tran )
plot(getData("/vdd!") getData("/I0/vdd!") getData("/OUT_INV") getData("/IN") )
save( 'i "/I2/vdd!" )
run()
selectResult( 'tran )
plot(getData("/I0/vdd!") getData("/IN") getData("/vdd!") getData("/I2/vdd!") )
run()
selectResult( 'tran )
plot(getData("/I0/vdd!") getData("/IN") getData("/vdd!") getData("/I2/vdd!") )
save( 'i /I2/vdd! )
run()
selectResult( 'tran )
plot(getData("/I0/vdd!") getData("/IN") getData("/OUT_INV") )
save( 'i "/I2/vdd!" )
run()
selectResult( 'tran )
plot(getData("/I0/vdd!") getData("/IN") getData("/OUT_INV") getData("/I2/vdd!") )
run()
selectResult( 'tran )
plot(getData("/I0/vdd!") getData("/IN") getData("/OUT_INV") getData("/I2/vdd!") )
run()
selectResult( 'tran )
plot(getData("/I0/vdd!") getData("/IN") getData("/OUT_INV") getData("/I2/vdd!") )
I_IN = IT("/I0/vdd!")
plot( I_IN ?expr '( "I_IN" ) )
save( 'i /I0/vdd! /I2/vdd! )
run()
selectResult( 'tran )
plot(getData("/IN") getData("/OUT_INV") )
I_IN = IT("/I0/vdd!")
plot( I_IN ?expr '( "I_IN" ) )
run()
selectResult( 'tran )
plot(getData("/IN") getData("/OUT_INV") )
I_IN = IT("/I0/vdd!")
plot( I_IN ?expr '( "I_IN" ) )

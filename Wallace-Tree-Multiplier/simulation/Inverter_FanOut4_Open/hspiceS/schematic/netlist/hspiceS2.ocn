simulator( 'hspiceS )
design(	 "/home/ecegrid/a/559mg3/cadence/simulation/Inverter_FanOut4_Open/hspiceS/schematic/netlist/Inverter_FanOut4_Open.C")
resultsDir( "/home/ecegrid/a/559mg3/cadence/simulation/Inverter_FanOut4_Open/hspiceS/schematic" )
analysis('tran ?from "0n"  ?to "30n"  ?by "1n"  )
save( 'i "/P0/S" )
temp( 25 )
run()
selectResult( 'tran )
plot(getData("/IN") getData("/OUT_INV") getData("/P0/S") )

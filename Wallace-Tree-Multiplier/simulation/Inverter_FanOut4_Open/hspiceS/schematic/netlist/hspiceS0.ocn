simulator( 'hspiceS )
design(	 "/home/ecegrid/a/559mg3/cadence/simulation/Inverter_FanOut4_Open/hspiceS/schematic/netlist/Inverter_FanOut4_Open.C")
resultsDir( "/home/ecegrid/a/559mg3/cadence/simulation/Inverter_FanOut4_Open/hspiceS/schematic" )
analysis('tran ?from "0n"  ?to "120n"  ?by "1n"  )
temp( 25 )
run()
selectResult( 'tran )
plot(getData("/OUT_INV") getData("/IN") )
I_IN = IT("/I0/vdd!")
plot( I_IN ?expr '( "I_IN" ) )
run()
selectResult( 'tran )
plot(getData("/IN") getData("/OUT_INV") )
I_IN = IT("/I0/vdd!")
plot( I_IN ?expr '( "I_IN" ) )

simulator( 'hspiceS )
design(	 "/home/ecegrid/a/559mg3/cadence/simulation/TSPC_FF_PositveEdge/hspiceS/schematic/netlist/TSPC_FF_PositveEdge.C")
resultsDir( "/home/ecegrid/a/559mg3/cadence/simulation/TSPC_FF_PositveEdge/hspiceS/schematic" )
analysis('tran ?from "0n"  ?to "60n"  ?by "1n"  )
temp( 25 )
run()
selectResult( 'tran )
plot(getData("/Q_OUT") getData("/clk") getData("/D_IN") )
run()
selectResult( 'tran )
plot(getData("/Q_OUT") getData("/clk") getData("/D_IN") )
run()
selectResult( 'tran )
plot(getData("/Q_OUT") getData("/clk") getData("/D_IN") )
run()
selectResult( 'tran )
plot(getData("/Q_OUT") getData("/clk") getData("/D_IN") )
run()
selectResult( 'tran )
plot(getData("/Q_OUT") getData("/clk") getData("/D_IN") )

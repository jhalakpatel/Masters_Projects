simulator( 'hspiceS )
design(	 "/home/ecegrid/a/559mg3/cadence/simulation/FF_Positive_edge/hspiceS/schematic/netlist/FF_Positive_edge.C")
resultsDir( "/home/ecegrid/a/559mg3/cadence/simulation/FF_Positive_edge/hspiceS/schematic" )
analysis('tran ?from "0n"  ?to "60n"  ?by "1n"  )
temp( 25 )
run()
selectResult( 'tran )
plot(getData("/clk") getData("/D_IN") getData("/Q_OUT") )
run()
selectResult( 'tran )
plot(getData("/clk") getData("/D_IN") getData("/Q_OUT") )
run()
selectResult( 'tran )
plot(getData("/clk") getData("/D_IN") getData("/Q_OUT") )
run()
selectResult( 'tran )
plot(getData("/clk") getData("/D_IN") getData("/Q_OUT") )
run()
selectResult( 'tran )
plot(getData("/VD") getData("/GD") getData("/Q_OUT") getData("/D_IN") getData("/clk") )
run()
selectResult( 'tran )
plot(getData("/Q_OUT") getData("/clk") getData("/D_IN") )

simulator( 'hspiceS )
design(	 "/home/ecegrid/a/559mg3/cadence/simulation/FF_Positive_edge/hspiceS/schematic/netlist/FF_Positive_edge.C")
resultsDir( "/home/ecegrid/a/559mg3/cadence/simulation/FF_Positive_edge/hspiceS/schematic" )
analysis('tran ?from "0n"  ?to "60n"  ?by "1n"  )
temp( 25 )
run()
selectResult( 'tran )
plot(getData("/Q_OUT") getData("/clk") )
delay = delay(VT("/clk") 1.25 1 "rising" VT("/Q_OUT") 1.25 1 "either" 0 0 nil nil)
plot( delay ?expr '( "delay" ) )

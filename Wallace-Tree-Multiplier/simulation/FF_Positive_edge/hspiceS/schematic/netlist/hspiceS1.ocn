simulator( 'hspiceS )
design(	 "/home/ecegrid/a/559mg3/cadence/simulation/FF_Positive_edge/hspiceS/schematic/netlist/FF_Positive_edge.C")
resultsDir( "/home/ecegrid/a/559mg3/cadence/simulation/FF_Positive_edge/hspiceS/schematic" )
analysis('tran ?from "0n"  ?to "60n"  ?by "1n"  )
temp( 25 )
run()
selectResult( 'tran )
plot(getData("/GD") getData("/VD") getData("/clk") getData("/D_IN") getData("/Q_OUT") )
run()
selectResult( 'tran )
plot(getData("/GD") getData("/VD") getData("/clk") getData("/D_IN") getData("/Q_OUT") )
run()
selectResult( 'tran )
plot(getData("/GD") getData("/VD") getData("/clk") getData("/D_IN") getData("/Q_OUT") )

simulator( 'hspiceS )
design(	 "/home/ecegrid/a/559mg3/cadence/simulation/XOR21_StaticCMOS/hspiceS/schematic/netlist/XOR21_StaticCMOS.C")
resultsDir( "/home/ecegrid/a/559mg3/cadence/simulation/XOR21_StaticCMOS/hspiceS/schematic" )
analysis('tran ?from "0n"  ?to "60n"  ?by "1n"  )
temp( 25 )
run()
selectResult( 'tran )
plot(getData("/B_IN") getData("/A_IN") getData("/OUT_XOR21") )
run()
selectResult( 'tran )
plot(getData("/B_IN") getData("/A_IN") getData("/OUT_XOR21") )
run()
selectResult( 'tran )
plot(getData("/B_IN") getData("/A_IN") getData("/OUT_XOR21") )
T_RISE = delay(VT("/OUT_XOR21") 0.9 1 "rising" VT("/A_IN") 0.9 1 "falling" 0 0 nil nil)
plot( T_RISE ?expr '( "T_RISE" ) )

simulator( 'hspiceS )
design(	 "/home/ecegrid/a/559mg3/cadence/simulation/XOR21_StaticCMOS/hspiceS/schematic/netlist/XOR21_StaticCMOS.C")
resultsDir( "/home/ecegrid/a/559mg3/cadence/simulation/XOR21_StaticCMOS/hspiceS/schematic" )
analysis('tran ?from "0n"  ?to "60n"  ?by "1n"  )
temp( 25 )
run()
selectResult( 'tran )
plot(getData("/B_IN") getData("/A_IN") getData("/OUT_XOR21") )

simulator( 'hspiceS )
design(	 "/home/ecegrid/a/559mg3/cadence/simulation/CMOS_NAND_180nm/hspiceS/schematic/netlist/CMOS_NAND_180nm.C")
resultsDir( "/home/ecegrid/a/559mg3/cadence/simulation/CMOS_NAND_180nm/hspiceS/schematic" )
analysis('tran ?from "0n"  ?to "120n"  ?by "1n"  )
desVar(	  "R" 5	)
desVar(	  "WIDTHN" 270n	)
desVar(	  "WIDTHP" 270n	)
temp( 25 )
run()
selectResult( 'tran )
plot(getData("/B") getData("/A") getData("/OUT") )
t_rise = delay(VT("/OUT") 1.25 1 "rising" VT("/B") 1.25 1 "falling" 0 0 nil nil)
plot( t_rise ?expr '( "t_rise" ) )
t_fall = delay(VT("/OUT") 1.25 1 "rising" VT("/A") 1.25 1 "falling" 0 0 nil nil)
plot( t_fall ?expr '( "t_fall" ) )
desVar(	  "R" 3	)
run()
selectResult( 'tran )
plot(getData("/B") getData("/A") getData("/OUT") )
t_rise = delay(VT("/OUT") 1.25 1 "rising" VT("/B") 1.25 1 "falling" 0 0 nil nil)
plot( t_rise ?expr '( "t_rise" ) )
t_fall = delay(VT("/OUT") 1.25 1 "rising" VT("/A") 1.25 1 "falling" 0 0 nil nil)
plot( t_fall ?expr '( "t_fall" ) )
run()
selectResult( 'tran )
plot(getData("/B") getData("/A") getData("/OUT") )
t_rise = delay(VT("/OUT") 1.25 1 "rising" VT("/B") 1.25 1 "falling" 0 0 nil nil)
plot( t_rise ?expr '( "t_rise" ) )
t_fall = delay(VT("/OUT") 1.25 1 "rising" VT("/A") 1.25 1 "falling" 0 0 nil nil)
plot( t_fall ?expr '( "t_fall" ) )
run()
selectResult( 'tran )
plot(getData("/OUT") getData("/A") getData("/B") )
t_rise = delay(VT("/OUT") 1.25 1 "falling" VT("/B") 1.25 1 "rising" 0 0 nil nil)
plot( t_rise ?expr '( "t_rise" ) )
t_fall = delay(VT("/OUT") 1.25 1 "falling" VT("/A") 1.25 1 "rising" 0 0 nil nil)
plot( t_fall ?expr '( "t_fall" ) )
run()
selectResult( 'tran )
plot(getData("/OUT") getData("/A") getData("/B") )
t_rise = delay(VT("/OUT") 1.25 1 "rising" VT("/B") 1.25 1 "falling" 0 0 nil nil)
plot( t_rise ?expr '( "t_rise" ) )
t_fall = delay(VT("/OUT") 1.25 1 "falling" VT("/A") 1.25 1 "rising" 0 0 nil nil)
plot( t_fall ?expr '( "t_fall" ) )
run()
selectResult( 'tran )
plot(getData("/OUT") getData("/A") getData("/B") )
t_rise = delay(VT("/OUT") 1.25 1 "rising" VT("/B") 1.25 1 "falling" 0 0 nil nil)
plot( t_rise ?expr '( "t_rise" ) )
t_fall = delay(VT("/OUT") 1.25 1 "falling" VT("/A") 1.25 1 "rising" 0 0 nil nil)
plot( t_fall ?expr '( "t_fall" ) )
run()
selectResult( 'tran )
plot(getData("/OUT") getData("/A") getData("/B") )
t_rise = delay(VT("/OUT") 1.25 1 "rising" VT("/B") 1.25 1 "falling" 0 0 nil nil)
plot( t_rise ?expr '( "t_rise" ) )
t_fall = delay(VT("/OUT") 1.25 1 "falling" VT("/B") 1.25 1 "rising" 0 0 nil nil)
plot( t_fall ?expr '( "t_fall" ) )
desVar(	  "R" 1	)
desVar(	  "WIDTHN" 360n	)
run()
selectResult( 'tran )
plot(getData("/OUT") getData("/A") getData("/B") )
t_rise = delay(VT("/OUT") 1.25 1 "rising" VT("/B") 1.25 1 "falling" 0 0 nil nil)
plot( t_rise ?expr '( "t_rise" ) )
t_fall = delay(VT("/OUT") 1.25 1 "falling" VT("/B") 1.25 1 "rising" 0 0 nil nil)
plot( t_fall ?expr '( "t_fall" ) )
desVar(	  "WIDTHN" 540n	)
run()
selectResult( 'tran )
plot(getData("/OUT") getData("/A") getData("/B") )
t_rise = delay(VT("/OUT") 1.25 1 "rising" VT("/B") 1.25 1 "falling" 0 0 nil nil)
plot( t_rise ?expr '( "t_rise" ) )
t_fall = delay(VT("/OUT") 1.25 1 "falling" VT("/B") 1.25 1 "rising" 0 0 nil nil)
plot( t_fall ?expr '( "t_fall" ) )
desVar(	  "WIDTHN" 360n	)
run()
selectResult( 'tran )
plot(getData("/OUT") getData("/A") getData("/B") )
t_rise = delay(VT("/OUT") 1.25 1 "rising" VT("/B") 1.25 1 "falling" 0 0 nil nil)
plot( t_rise ?expr '( "t_rise" ) )
t_fall = delay(VT("/OUT") 1.25 1 "falling" VT("/B") 1.25 1 "rising" 0 0 nil nil)
plot( t_fall ?expr '( "t_fall" ) )
desVar(	  "WIDTHP" 360n	)
run()
selectResult( 'tran )
plot(getData("/OUT") getData("/A") getData("/B") )
t_rise = delay(VT("/OUT") 1.25 1 "rising" VT("/B") 1.25 1 "falling" 0 0 nil nil)
plot( t_rise ?expr '( "t_rise" ) )
t_fall = delay(VT("/OUT") 1.25 1 "falling" VT("/B") 1.25 1 "rising" 0 0 nil nil)
plot( t_fall ?expr '( "t_fall" ) )
desVar(	  "R" 3	)
desVar(	  "WIDTHN" 270n	)
desVar(	  "WIDTHP" 270n	)
run()
selectResult( 'tran )
plot(getData("/OUT") getData("/A") getData("/B") )
t_rise = delay(VT("/OUT") 0.25 1 "rising" VT("/OUT") 2.25 1 "rising" 0 0 nil nil)
plot( t_rise ?expr '( "t_rise" ) )
t_fall = delay(VT("/OUT") 2.25 1 "falling" VT("/OUT") 0.25 1 "falling" 0 0 nil nil)
plot( t_fall ?expr '( "t_fall" ) )
desVar(	  "R" 4	)
run()
selectResult( 'tran )
plot(getData("/OUT") getData("/A") getData("/B") )
t_rise = delay(VT("/OUT") 0.25 1 "rising" VT("/OUT") 2.25 1 "rising" 0 0 nil nil)
plot( t_rise ?expr '( "t_rise" ) )
t_fall = delay(VT("/OUT") 2.25 1 "falling" VT("/OUT") 0.25 1 "falling" 0 0 nil nil)
plot( t_fall ?expr '( "t_fall" ) )
desVar(	  "R" 2	)
run()
selectResult( 'tran )
plot(getData("/OUT") getData("/A") getData("/B") )
t_rise = delay(VT("/OUT") 0.25 1 "rising" VT("/OUT") 2.25 1 "rising" 0 0 nil nil)
plot( t_rise ?expr '( "t_rise" ) )
t_fall = delay(VT("/OUT") 2.25 1 "falling" VT("/OUT") 0.25 1 "falling" 0 0 nil nil)
plot( t_fall ?expr '( "t_fall" ) )
desVar(	  "R" 3.5	)
run()
selectResult( 'tran )
plot(getData("/OUT") getData("/A") getData("/B") )
t_rise = delay(VT("/B") 1.25 1 "falling" VT("/OUT") 1.25 1 "rising" 0 0 nil nil)
plot( t_rise ?expr '( "t_rise" ) )
t_fall = delay(VT("/B") 2.25 1 "rising" VT("/OUT") 0.25 1 "falling" 0 0 nil nil)
plot( t_fall ?expr '( "t_fall" ) )
desVar(	  "R" 4	)
run()
selectResult( 'tran )
plot(getData("/OUT") getData("/A") getData("/B") )
t_rise = delay(VT("/B") 1.25 1 "falling" VT("/OUT") 1.25 1 "rising" 0 0 nil nil)
plot( t_rise ?expr '( "t_rise" ) )
t_fall = delay(VT("/B") 2.25 1 "rising" VT("/OUT") 0.25 1 "falling" 0 0 nil nil)
plot( t_fall ?expr '( "t_fall" ) )
desVar(	  "R" 1	)
desVar(	  "WIDTHN" 360n	)
run()
selectResult( 'tran )
plot(getData("/OUT") getData("/A") getData("/B") )
t_rise = delay(VT("/B") 1.25 1 "falling" VT("/OUT") 1.25 1 "rising" 0 0 nil nil)
plot( t_rise ?expr '( "t_rise" ) )
t_fall = delay(VT("/B") 1.25 1 "rising" VT("/OUT") 1.25 1 "falling" 0 0 nil nil)
plot( t_fall ?expr '( "t_fall" ) )
desVar(	  "WIDTHN" 450n	)
run()
selectResult( 'tran )
plot(getData("/OUT") getData("/A") getData("/B") )
t_rise = delay(VT("/B") 1.25 1 "falling" VT("/OUT") 1.25 1 "rising" 0 0 nil nil)
plot( t_rise ?expr '( "t_rise" ) )
t_fall = delay(VT("/B") 1.25 1 "rising" VT("/OUT") 1.25 1 "falling" 0 0 nil nil)
plot( t_fall ?expr '( "t_fall" ) )
desVar(	  "WIDTHN" 360n	)
run()
selectResult( 'tran )
plot(getData("/OUT") getData("/A") getData("/B") )
t_rise = delay(VT("/B") 1.25 1 "falling" VT("/OUT") 1.25 1 "rising" 0 0 nil nil)
plot( t_rise ?expr '( "t_rise" ) )
t_fall = delay(VT("/B") 1.25 1 "rising" VT("/OUT") 1.25 1 "falling" 0 0 nil nil)
plot( t_fall ?expr '( "t_fall" ) )
desVar(	  "WIDTHP" 360n	)
run()
selectResult( 'tran )
plot(getData("/OUT") getData("/A") getData("/B") )
t_rise = delay(VT("/B") 1.25 1 "falling" VT("/OUT") 1.25 1 "rising" 0 0 nil nil)
plot( t_rise ?expr '( "t_rise" ) )
t_fall = delay(VT("/B") 1.25 1 "rising" VT("/OUT") 1.25 1 "falling" 0 0 nil nil)
plot( t_fall ?expr '( "t_fall" ) )
desVar(	  "WIDTHP" 450n	)
run()
selectResult( 'tran )
plot(getData("/OUT") getData("/A") getData("/B") )
t_rise = delay(VT("/B") 1.25 1 "falling" VT("/OUT") 1.25 1 "rising" 0 0 nil nil)
plot( t_rise ?expr '( "t_rise" ) )
t_fall = delay(VT("/B") 1.25 1 "rising" VT("/OUT") 1.25 1 "falling" 0 0 nil nil)
plot( t_fall ?expr '( "t_fall" ) )
desVar(	  "WIDTHN" 400n	)
desVar(	  "WIDTHP" 360n	)
run()
selectResult( 'tran )
plot(getData("/OUT") getData("/A") getData("/B") )
t_rise = delay(VT("/B") 1.25 1 "falling" VT("/OUT") 1.25 1 "rising" 0 0 nil nil)
plot( t_rise ?expr '( "t_rise" ) )
t_fall = delay(VT("/B") 1.25 1 "rising" VT("/OUT") 1.25 1 "falling" 0 0 nil nil)
plot( t_fall ?expr '( "t_fall" ) )
desVar(	  "WIDTHN" 360n	)
run()
selectResult( 'tran )
plot(getData("/OUT") getData("/A") getData("/B") )
t_rise = delay(VT("/B") 1.25 1 "falling" VT("/OUT") 1.25 1 "rising" 0 0 nil nil)
plot( t_rise ?expr '( "t_rise" ) )
t_fall = delay(VT("/B") 1.25 1 "rising" VT("/OUT") 1.25 1 "falling" 0 0 nil nil)
plot( t_fall ?expr '( "t_fall" ) )
desVar(	  "WIDTHN" 540n	)
desVar(	  "WIDTHP" 450n	)
run()
selectResult( 'tran )
plot(getData("/OUT") getData("/A") getData("/B") )
t_rise = delay(VT("/B") 1.25 1 "falling" VT("/OUT") 1.25 1 "rising" 0 0 nil nil)
plot( t_rise ?expr '( "t_rise" ) )
t_fall = delay(VT("/B") 1.25 1 "rising" VT("/OUT") 1.25 1 "falling" 0 0 nil nil)
plot( t_fall ?expr '( "t_fall" ) )
desVar(	  "WIDTHN" 630n	)
run()
selectResult( 'tran )
plot(getData("/OUT") getData("/A") getData("/B") )
t_rise = delay(VT("/B") 1.25 1 "falling" VT("/OUT") 1.25 1 "rising" 0 0 nil nil)
plot( t_rise ?expr '( "t_rise" ) )
t_fall = delay(VT("/B") 1.25 1 "rising" VT("/OUT") 1.25 1 "falling" 0 0 nil nil)
plot( t_fall ?expr '( "t_fall" ) )
desVar(	  "WIDTHN" 270n	)
desVar(	  "WIDTHP" 540n	)
run()
selectResult( 'tran )
plot(getData("/OUT") getData("/A") getData("/B") )
t_rise = delay(VT("/B") 1.25 1 "falling" VT("/OUT") 1.25 1 "rising" 0 0 nil nil)
plot( t_rise ?expr '( "t_rise" ) )
t_fall = delay(VT("/B") 1.25 1 "rising" VT("/OUT") 1.25 1 "falling" 0 0 nil nil)
plot( t_fall ?expr '( "t_fall" ) )
run()
selectResult( 'tran )
plot(getData("/OUT") getData("/A") getData("/B") )
t_rise = delay(VT("/OUT") 1.25 1 "rising" VT("/B") 1.25 1 "falling" 0 0 nil nil)
plot( t_rise ?expr '( "t_rise" ) )
t_fall = delay(VT("/B") 1.25 1 "rising" VT("/OUT") 1.25 1 "falling" 0 0 nil nil)
plot( t_fall ?expr '( "t_fall" ) )
run()
selectResult( 'tran )
plot(getData("/OUT") getData("/A") getData("/B") )
t_rise = delay(VT("/OUT") 1.25 1 "rising" VT("/B") 1.25 1 "falling" 0 0 nil nil)
plot( t_rise ?expr '( "t_rise" ) )
t_fall = delay(VT("/OUT") 1.25 1 "falling" VT("/B") 1.25 1 "rising" 0 0 nil nil)
plot( t_fall ?expr '( "t_fall" ) )
run()
selectResult( 'tran )
plot(getData("/OUT") getData("/A") getData("/B") )
t_rise = delay(VT("/OUT") 1.25 1 "rising" VT("/B") 1.25 1 "falling" 0 0 nil nil)
plot( t_rise ?expr '( "t_rise" ) )
t_fall = delay(VT("/B") 1.25 1 "rising" VT("/OUT") 1.25 1 "falling" 0 0 nil nil)
plot( t_fall ?expr '( "t_fall" ) )
desVar(	  "R" 3.8	)
desVar(	  "WIDTHP" 270n	)
run()
selectResult( 'tran )
plot(getData("/OUT") getData("/A") getData("/B") )
t_rise = delay(VT("/OUT") 1.25 1 "rising" VT("/B") 1.25 1 "falling" 0 0 nil nil)
plot( t_rise ?expr '( "t_rise" ) )
t_fall = delay(VT("/B") 1.25 1 "rising" VT("/OUT") 1.25 1 "falling" 0 0 nil nil)
plot( t_fall ?expr '( "t_fall" ) )
desVar(	  "R" 4	)
run()
selectResult( 'tran )
plot(getData("/OUT") getData("/A") getData("/B") )
t_rise = delay(VT("/OUT") 1.25 1 "rising" VT("/B") 1.25 1 "falling" 0 0 nil nil)
plot( t_rise ?expr '( "t_rise" ) )
t_fall = delay(VT("/B") 1.25 1 "rising" VT("/OUT") 1.25 1 "falling" 0 0 nil nil)
plot( t_fall ?expr '( "t_fall" ) )

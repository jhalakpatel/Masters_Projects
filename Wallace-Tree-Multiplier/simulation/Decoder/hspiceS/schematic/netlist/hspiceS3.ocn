simulator( 'hspiceS )
design(	 "/home/ecegrid/a/559mg3/cadence/simulation/Decoder/hspiceS/schematic/netlist/Decoder.C")
resultsDir( "/home/ecegrid/a/559mg3/cadence/simulation/Decoder/hspiceS/schematic" )
analysis('tran ?from "0n"  ?to "60n"  ?by "1n"  )
temp( 25 )
run()
selectResult( 'tran )
plot(getData("/c_in_3") getData("/p_in_3") getData("/c_in_2") getData("/p_in_2") getData("/p_in_1") getData("/clk") getData("/d_out") getData("/decode_out") )
run()
selectResult( 'tran )
plot(getData("/c_in_3") getData("/p_in_3") getData("/c_in_2") getData("/p_in_2") getData("/p_in_1") getData("/clk") getData("/d_out") getData("/decode_out") )
run()
selectResult( 'tran )
plot(getData("/nand_out") getData("/ff_out") getData("/xor_out") getData("/net9") getData("/xor_3") getData("/xor_2") getData("/xor_1") getData("/c_in_3") getData("/p_in_3") getData("/c_in_2") getData("/p_in_2") getData("/p_in_1") getData("/clk") getData("/d_out") getData("/decode_out") )
run()
selectResult( 'tran )
plot(getData("/and_out") getData("/ff_out") getData("/clk") getData("/clk_n") getData("/nand_out") getData("/and_going_in_or_2") getData("/and_going_in_or_!") getData("/d_out") )

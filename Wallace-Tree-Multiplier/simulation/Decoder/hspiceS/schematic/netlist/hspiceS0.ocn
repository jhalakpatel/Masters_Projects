simulator( 'hspiceS )
design(	 "/home/ecegrid/a/559mg3/cadence/simulation/Decoder/hspiceS/schematic/netlist/Decoder.C")
resultsDir( "/home/ecegrid/a/559mg3/cadence/simulation/Decoder/hspiceS/schematic" )
analysis('tran ?from "0n"  ?to "60n"  ?by "1n"  )
temp( 25 )
run()
selectResult( 'tran )
plot(getData("/c_in_3") getData("/p_in_3") getData("/c_in_2") getData("/p_in_2") getData("/c_in_1") getData("/p_in_1") getData("/decode_out") )
run()
selectResult( 'tran )
plot(getData("/GD") getData("/VD") getData("/clk") getData("/c_in_3") getData("/p_in_3") getData("/c_in_2") getData("/p_in_2") getData("/c_in_1") getData("/p_in_1") getData("/decode_out") )
run()
selectResult( 'tran )
plot(getData("/net057") getData("/GD") getData("/VD") getData("/clk") getData("/c_in_3") getData("/p_in_3") getData("/c_in_2") getData("/p_in_2") getData("/c_in_1") getData("/p_in_1") getData("/decode_out") )
run()
selectResult( 'tran )
plot(getData("/net057") getData("/GD") getData("/VD") getData("/clk") getData("/c_in_3") getData("/p_in_3") getData("/c_in_2") getData("/p_in_2") getData("/c_in_1") getData("/p_in_1") getData("/decode_out") )
run()
selectResult( 'tran )
plot(getData("/net057") getData("/GD") getData("/VD") getData("/clk") getData("/c_in_3") getData("/p_in_3") getData("/c_in_2") getData("/p_in_2") getData("/c_in_1") getData("/p_in_1") getData("/decode_out") )
run()
selectResult( 'tran )
plot(getData("/net16") getData("/net7") getData("/net26") getData("/net057") getData("/GD") getData("/VD") getData("/clk") getData("/c_in_3") getData("/p_in_3") getData("/c_in_2") getData("/p_in_2") getData("/c_in_1") getData("/p_in_1") getData("/decode_out") )
run()
selectResult( 'tran )
plot(getData("/c_in_1") getData("/p_in_1") getData("/net26") )
run()
selectResult( 'tran )
plot(getData("/net7") getData("/c_in_2") getData("/p_in_2") getData("/c_in_1") getData("/p_in_1") getData("/net26") )
run()
selectResult( 'tran )
plot(getData("/net7") getData("/c_in_2") getData("/p_in_2") getData("/c_in_1") getData("/p_in_1") getData("/net26") )
run()
selectResult( 'tran )
plot(getData("/net7") getData("/c_in_2") getData("/p_in_2") getData("/c_in_1") getData("/p_in_1") getData("/net26") )
run()
selectResult( 'tran )
plot(getData("/net7") getData("/c_in_2") getData("/p_in_2") getData("/c_in_1") getData("/p_in_1") getData("/net26") )
run()
selectResult( 'tran )
plot(getData("/net16") getData("/net7") getData("/net26") getData("/c_in_3") getData("/p_in_3") getData("/c_in_2") getData("/p_in_2") getData("/c_in_1") getData("/p_in_1") )
run()
selectResult( 'tran )
plot(getData("/xor_3") getData("/xor_2") getData("/xor_1") getData("/c_in_3") getData("/p_in_3") getData("/c_in_2") getData("/p_in_2") getData("/c_in_1") getData("/p_in_1") )
run()
selectResult( 'tran )
plot(getData("/p_in_1") getData("/c_in_1") getData("/p_in_2") getData("/c_in_2") getData("/p_in_3") getData("/c_in_3") getData("/net070") )
run()
selectResult( 'tran )
plot(getData("/p_in_1") getData("/c_in_1") getData("/p_in_2") getData("/c_in_2") getData("/p_in_3") getData("/c_in_3") getData("/net070") )
run()
selectResult( 'tran )
plot(getData("/net057") getData("/net045") getData("/clk") getData("/decode_out") getData("/net070") getData("/c_in_3") getData("/p_in_3") getData("/c_in_2") getData("/p_in_2") getData("/c_in_1") getData("/p_in_1") )
run()
selectResult( 'tran )
plot(getData("/net065") getData("/net060") getData("/nand_out") getData("/clk_n") getData("/d_out") getData("/clk") getData("/ff_out") getData("/xor_out") getData("/net9") getData("/xor_3") getData("/c_in_3") getData("/p_in_3") getData("/xor_2") getData("/c_in_2") getData("/p_in_2") getData("/xor_1") getData("/c_in_1") getData("/p_in_1") )
run()
selectResult( 'tran )
plot(getData("/net065") getData("/net060") getData("/nand_out") getData("/clk_n") getData("/d_out") getData("/clk") getData("/ff_out") getData("/xor_out") getData("/net9") getData("/xor_3") getData("/c_in_3") getData("/p_in_3") getData("/xor_2") getData("/c_in_2") getData("/p_in_2") getData("/xor_1") getData("/c_in_1") getData("/p_in_1") )

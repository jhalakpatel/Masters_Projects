simulator( 'hspiceS )
design(	 "/home/ecegrid/a/559mg3/cadence/simulation/Decoder/hspiceS/schematic/netlist/Decoder.C")
resultsDir( "/home/ecegrid/a/559mg3/cadence/simulation/Decoder/hspiceS/schematic" )
analysis('tran ?from "0n"  ?to "60n"  ?by "1n"  )
temp( 25 )
run()
selectResult( 'tran )
plot(getData("/decode_out") getData("/nand_out") getData("/ff_out") getData("/d_out") )
run()
selectResult( 'tran )
plot(getData("/and_out") getData("/decode_out") getData("/nand_out") getData("/ff_out") getData("/d_out") )
run()
selectResult( 'tran )
plot(getData("/nand_out") getData("/d_out") getData("/clk") getData("/clk_n") getData("/and_out") getData("/decode_out") getData("/ff_out") )

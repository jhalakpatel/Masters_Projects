simulator( 'hspiceS )
design(	 "/home/ecegrid/a/559mg3/cadence/simulation/Decoder/hspiceS/schematic/netlist/Decoder.C")
resultsDir( "/home/ecegrid/a/559mg3/cadence/simulation/Decoder/hspiceS/schematic" )
analysis('tran ?from "0n"  ?to "60n"  ?by "1n"  )
temp( 25 )
run()
selectResult( 'tran )
plot(getData("/clk") getData("/d_out") getData("/c_in_3") getData("/p_in_3") getData("/c_in_2") getData("/p_in_2") getData("/c_in_1") getData("/p_in_1") )
run()
selectResult( 'tran )
plot(getData("/clk") getData("/d_out") getData("/c_in_3") getData("/p_in_3") getData("/c_in_2") getData("/p_in_2") getData("/c_in_1") getData("/p_in_1") )
run()
selectResult( 'tran )
plot(getData("/clk") getData("/d_out") getData("/c_in_3") getData("/p_in_3") getData("/c_in_2") getData("/p_in_2") getData("/c_in_1") getData("/p_in_1") )

simulator( 'hspiceS )
design(	 "/home/ecegrid/a/559mg3/cadence/simulation/Domino_OR/hspiceS/schematic/netlist/Domino_OR.C")
resultsDir( "/home/ecegrid/a/559mg3/cadence/simulation/Domino_OR/hspiceS/schematic" )
analysis('tran ?from "0n"  ?to "120n"  ?by "1n"  )
temp( 25 )
run()
run()
selectResult( 'tran )
plot(getData("/A") getData("/B") getData("/CLK") getData("/OUT") )
run()
selectResult( 'tran )
plot(getData("/A") getData("/B") getData("/CLK") getData("/OUT") )
run()
selectResult( 'tran )
plot(getData("/B") getData("/A") getData("/OUT") getData("/CLK") )
run()
selectResult( 'tran )
plot(getData("/B") getData("/A") getData("/OUT") getData("/CLK") )
run()
selectResult( 'tran )
plot(getData("/B") getData("/A") getData("/OUT") getData("/CLK") )
run()
selectResult( 'tran )
plot(getData("/B") getData("/A") getData("/OUT") getData("/CLK") )

simulator( 'hspiceS )
design(	 "/home/ecegrid/a/559mg3/cadence/simulation/InverterTest/hspiceS/schematic/netlist/InverterTest.C")
resultsDir( "/home/ecegrid/a/559mg3/cadence/simulation/InverterTest/hspiceS/schematic" )
analysis('tran ?from "0n"  ?to "30n"  ?by "1n"  )
temp( 25 )
run()
selectResult( 'tran )
plot(getData("/in<0>") getData("/in<1>") getData("/out<0>") getData("/out<1>") )
createFinalNetlist()
